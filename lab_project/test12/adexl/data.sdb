ADE simulation setup
Run mode: Single Run, Sweeps and Corners
Tests:
  lab2_project:Frequency_Devider_by_2_part1:1: lab2_project/Frequency_Devider_by_2_part1/schematic, simulator spectre
    Outputs: FOM
Global variables:
  f = 1*K*1G
  V_supply = .8
  WN = 200
  WP = 250
  K = 1,2,3,4,5,6,7,8,9,10,11
  CAP = 1
