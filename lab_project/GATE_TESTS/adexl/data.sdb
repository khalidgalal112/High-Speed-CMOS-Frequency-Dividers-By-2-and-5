ADE simulation setup
Run mode: Single Run, Sweeps and Corners
Tests:
  lab2_project:GATE_TESTS:1: lab2_project/GATE_TESTS/schematic, simulator spectre
