ADE simulation setup
Run mode: Single Run, Sweeps and Corners
Tests:
  lab2_project:Devide_by_5:1: lab2_project/Devide_by_5/schematic, simulator spectre
    Outputs: \)
Global variables:
  f = 11G
  V_SUP = .8
