ADE simulation setup
Run mode: Single Run, Sweeps and Corners
Tests:
  lab2_project:DFF_TEST:1: lab2_project/DFF_TEST/schematic, simulator spectre
Global variables:
  vdd = .61 (off)
